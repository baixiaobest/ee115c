// Design: project_lib/TEST_COMPARATOR
simulator lang=spectre
global 0 vdd!
include "/usr/public.2/ee115c/cadence-labs/gpdk090_v3.4/models/spectre/gpdk090.scs" section=NN

// project_lib/INV/schematic
subckt INV GND VDD Vin Vout
    NM0 (Vout Vin GND GND) gpdk090_nmos1v w=(430n) l=100n m=(1)*(1)
    PM0 (Vout Vin VDD VDD) gpdk090_pmos1v w=(650n) l=100n m=(1)*(1)
ends INV

// project_lib/NAND/schematic
subckt NAND A B GND OUT VDD
    NM0 (OUT A net45 GND) gpdk090_nmos1v w=(860n) l=100n m=(1)*(1)
    NM1 (net45 B GND GND) gpdk090_nmos1v w=(860n) l=100n m=(1)*(1)
    PM0 (OUT A VDD VDD) gpdk090_pmos1v w=(650n) l=100n m=(1)*(1)
    PM1 (OUT B VDD VDD) gpdk090_pmos1v w=(650n) l=100n m=(1)*(1)
ends NAND

// project_lib/NOR/schematic
subckt NOR A B GND OUT VDD
    NM1 (OUT B GND GND) gpdk090_nmos1v w=(430n) l=100n m=(1)*(1)
    NM0 (OUT A GND GND) gpdk090_nmos1v w=(430n) l=100n m=(1)*(1)
    PM1 (OUT B net15 VDD) gpdk090_pmos1v w=(1.3u) l=100n m=(1)*(1)
    PM0 (net15 A VDD VDD) gpdk090_pmos1v w=(1.3u) l=100n m=(1)*(1)
ends NOR

// project_lib/NANDx3/schematic
subckt NANDx3 A B C GND OUT VDD
    PM2 (OUT C VDD VDD) gpdk090_pmos1v w=(650n) l=100n m=(1)*(1)
    PM1 (OUT B VDD VDD) gpdk090_pmos1v w=(650n) l=100n m=(1)*(1)
    PM0 (OUT A VDD VDD) gpdk090_pmos1v w=(650n) l=100n m=(1)*(1)
    NM2 (net65 C GND GND) gpdk090_nmos1v w=(1.29u) l=100n m=(1)*(1)
    NM1 (net66 B net65 GND) gpdk090_nmos1v w=(1.29u) l=100n m=(1)*(1)
    NM0 (OUT A net66 GND) gpdk090_nmos1v w=(1.29u) l=100n m=(1)*(1)
ends NANDx3

// project_lib/NANDx4/schematic
subckt NANDx4 A B C D GND OUT VDD
    PM3 (OUT D VDD VDD) gpdk090_pmos1v w=(650n) l=100n m=(1)*(1)
    PM2 (OUT C VDD VDD) gpdk090_pmos1v w=(650n) l=100n m=(1)*(1)
    PM1 (OUT B VDD VDD) gpdk090_pmos1v w=(650n) l=100n m=(1)*(1)
    PM0 (OUT A VDD VDD) gpdk090_pmos1v w=(650n) l=100n m=(1)*(1)
    NM3 (net83 D GND GND) gpdk090_nmos1v w=(1.72u) l=100n m=(1)*(1)
    NM2 (net84 C net83 GND) gpdk090_nmos1v w=(1.72u) l=100n m=(1)*(1)
    NM0 (OUT A net85 GND) gpdk090_nmos1v w=(1.72u) l=100n m=(1)*(1)
    NM1 (net85 B net84 GND) gpdk090_nmos1v w=(1.72u) l=100n m=(1)*(1)
ends NANDx4

// project_lib/NANDx5/schematic
subckt NANDx5 A B C D E GND OUT VDD
    PM4 (OUT E VDD VDD) gpdk090_pmos1v w=(650n) l=100n m=(1)*(1)
    PM3 (OUT D VDD VDD) gpdk090_pmos1v w=(650n) l=100n m=(1)*(1)
    PM2 (OUT C VDD VDD) gpdk090_pmos1v w=(650n) l=100n m=(1)*(1)
    PM1 (OUT B VDD VDD) gpdk090_pmos1v w=(650n) l=100n m=(1)*(1)
    PM0 (OUT A VDD VDD) gpdk090_pmos1v w=(650n) l=100n m=(1)*(1)
    NM4 (net102 E GND GND) gpdk090_nmos1v w=(2.15u) l=100n m=(1)*(1)
    NM3 (net99 D net102 GND) gpdk090_nmos1v w=(2.15u) l=100n m=(1)*(1)
    NM1 (net100 B net101 GND) gpdk090_nmos1v w=(2.15u) l=100n m=(1)*(1)
    NM2 (net101 C net99 GND) gpdk090_nmos1v w=(2.15u) l=100n m=(1)*(1)
    NM0 (OUT A net100 GND) gpdk090_nmos1v w=(2.15u) l=100n m=(1)*(1)
ends NANDx5

// project_lib/COMPARATOR_S/schematic
subckt COMPARATOR_S A0 A1 A2 A3 A4 B0 B1 B2 B3 B4 GND OUT VDD
    I26 (GND VDD A3 net0140) INV
    I28 (GND VDD B3 net0141) INV
    I38 (GND VDD A0 net0135) INV
    I36 (GND VDD B1 net0137) INV
    I72 (GND VDD net0111 net063) INV
    I30 (GND VDD A2 net0138) INV
    I32 (GND VDD B2 net0139) INV
    I34 (GND VDD A1 net0136) INV
    I1 (GND VDD A4 net0142) INV
    I0 (GND VDD B4 net0143) INV
    I67 (net0117 net0113 GND net0132 VDD) NAND
    I45 (net0112 net0123 GND net0130 VDD) NOR
    I44 (net0125 net0114 GND net0115 VDD) NOR
    I42 (net0128 net0111 GND net0117 VDD) NOR
    I43 (net0113 net0127 GND net0116 VDD) NOR
    I61 (A1 net0137 GND net0123 VDD) NOR
    I64 (B3 net0140 GND net0113 VDD) NOR
    I63 (B4 net0142 GND net0111 VDD) NOR
    I58 (A4 net0143 GND net0128 VDD) NOR
    I59 (A3 net0141 GND net0127 VDD) NOR
    I66 (B1 net0136 GND net0112 VDD) NOR
    I62 (net0135 B0 GND net0129 VDD) NOR
    I65 (B2 net0138 GND net0114 VDD) NOR
    I60 (A2 net0139 GND net0125 VDD) NOR
    I68 (net0117 net0116 net0114 GND net0144 VDD) NANDx3
    I69 (net0117 net0116 net0115 net0112 GND net0131 VDD) NANDx4
    I70 (net0129 net0130 net0115 net0116 net0117 GND net0134 VDD) NANDx5
    I71 (net063 net0132 net0144 net0131 net0134 GND OUT VDD) NANDx5
ends COMPARATOR_S

// project_lib/TEST_COMPARATOR/schematic
I3 (0 vdd! 0 0 vdd! 0 vdd! vdd! 0 0 0 OUT vdd!) COMPARATOR_S
include "./_graphical_stimuli.scs"
simulatorOptions options temp=27
tran tran stop=1u
