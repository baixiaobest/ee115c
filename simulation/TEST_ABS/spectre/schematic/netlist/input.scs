// Design: project_lib/TEST_ABS
simulator lang=spectre
global 0 vdd!
include "/usr/public.2/ee115c/cadence-labs/gpdk090_v3.4/models/spectre/gpdk090.scs" section=NN

// project_lib/INV/schematic
subckt INV GND VDD Vin Vout
    NM0 (Vout Vin GND GND) gpdk090_nmos1v w=(430n) l=100n m=(1)*(1)
    PM0 (Vout Vin VDD VDD) gpdk090_pmos1v w=(650n) l=100n m=(1)*(1)
ends INV

// project_lib/INV_5bit/schematic
subckt INV_5bit GND VDD Vin0 Vin1 Vin2 Vin3 Vin4 Vout0 Vout1 Vout2 Vout3 Vout4
    I4 (GND VDD Vin4 Vout4) INV
    I3 (GND VDD Vin3 Vout3) INV
    I2 (GND VDD Vin2 Vout2) INV
    I1 (GND VDD Vin1 Vout1) INV
    I0 (GND VDD Vin0 Vout0) INV
ends INV_5bit

// project_lib/MUX_1bit/schematic
subckt MUX_1bit A B GND OUT S VDD
    PM1 (OUT S A VDD) gpdk090_pmos1v w=(430n) l=100n m=(1)*(1)
    PM0 (OUT net15 B VDD) gpdk090_pmos1v w=(430n) l=100n m=(1)*(1)
    NM1 (OUT net15 A GND) gpdk090_nmos1v w=(430n) l=100n m=(1)*(1)
    NM0 (OUT S B GND) gpdk090_nmos1v w=(430n) l=100n m=(1)*(1)
    I2 (GND VDD S net15) INV
ends MUX_1bit

// project_lib/MUX_5bit/schematic
subckt MUX_5bit A0 A1 A2 A3 A4 B0 B1 B2 B3 B4 GND OUT0 OUT1 OUT2 OUT3 OUT4 S VDD
    I4 (A4 B4 GND OUT4 S VDD) MUX_1bit
    I3 (A3 B3 GND OUT3 S VDD) MUX_1bit
    I2 (A2 B2 GND OUT2 S VDD) MUX_1bit
    I1 (A1 B1 GND OUT1 S VDD) MUX_1bit
    I0 (A0 B0 GND OUT0 S VDD) MUX_1bit
ends MUX_5bit

// project_lib/FAdder/schematic
subckt FAdder \!Cout A B Cin GND S VDD
    NM12 (S net30 GND GND) gpdk090_nmos1v w=(430n) l=100n m=(1)*(1)
    NM11 (net024 A GND GND) gpdk090_nmos1v w=(1.29u) l=100n m=(1)*(1)
    NM10 (net025 B net024 GND) gpdk090_nmos1v w=(1.29u) l=100n m=(1)*(1)
    NM9 (net30 Cin net025 GND) gpdk090_nmos1v w=(1.29u) l=100n m=(1)*(1)
    NM8 (net19 Cin GND GND) gpdk090_nmos1v w=(860n) l=100n m=(1)*(1)
    NM7 (net19 A GND GND) gpdk090_nmos1v w=(860n) l=100n m=(1)*(1)
    NM6 (net19 B GND GND) gpdk090_nmos1v w=(860n) l=100n m=(1)*(1)
    NM5 (net30 \!Cout net19 GND) gpdk090_nmos1v w=(860n) l=100n m=(1)*(1)
    NM4 (\!Cout Cin net11 GND) gpdk090_nmos1v w=(860n) l=100n m=(1)*(1)
    NM3 (\!Cout A net059 GND) gpdk090_nmos1v w=(860n) l=100n m=(1)*(1)
    NM2 (net059 B GND GND) gpdk090_nmos1v w=(860n) l=100n m=(1)*(1)
    NM1 (net11 B GND GND) gpdk090_nmos1v w=(860n) l=100n m=(1)*(1)
    NM0 (net11 A GND GND) gpdk090_nmos1v w=(860n) l=100n m=(1)*(1)
    PM13 (S net30 VDD VDD) gpdk090_pmos1v w=(650n) l=100n m=(1)*(1)
    PM12 (net057 A VDD VDD) gpdk090_pmos1v w=(1.95u) l=100n m=(1)*(1)
    PM10 (net056 B net057 VDD) gpdk090_pmos1v w=(1.95u) l=100n m=(1)*(1)
    PM9 (net30 Cin net056 VDD) gpdk090_pmos1v w=(1.95u) l=100n m=(1)*(1)
    PM8 (net020 Cin VDD VDD) gpdk090_pmos1v w=(1.3u) l=100n m=(1)*(1)
    PM7 (net020 B VDD VDD) gpdk090_pmos1v w=(1.3u) l=100n m=(1)*(1)
    PM6 (net020 A VDD VDD) gpdk090_pmos1v w=(1.3u) l=100n m=(1)*(1)
    PM5 (net30 \!Cout net020 VDD) gpdk090_pmos1v w=(1.3u) l=100n m=(1)*(1)
    PM4 (\!Cout A net058 VDD) gpdk090_pmos1v w=(1.3u) l=100n m=(1)*(1)
    PM3 (net058 B VDD VDD) gpdk090_pmos1v w=(1.3u) l=100n m=(1)*(1)
    PM2 (net037 B VDD VDD) gpdk090_pmos1v w=(1.3u) l=100n m=(1)*(1)
    PM1 (net037 A VDD VDD) gpdk090_pmos1v w=(1.3u) l=100n m=(1)*(1)
    PM0 (\!Cout Cin net037 VDD) gpdk090_pmos1v w=(1.3u) l=100n m=(1)*(1)
ends FAdder

// project_lib/Adder_5bit/schematic
subckt Adder_5bit A0 A1 A2 A3 A4 B0 B1 B2 B3 B4 Cin Cout GND S0 S1 S2 S3 S4 VDD
    I4 (Cout A4 B4 net50 GND S4 VDD) FAdder
    I3 (net50 net051 net050 net19 GND S3 VDD) FAdder
    I2 (net19 A2 B2 net20 GND S2 VDD) FAdder
    I1 (net20 net040 net055 net56 GND S1 VDD) FAdder
    I0 (net56 A0 B0 Cin GND S0 VDD) FAdder
    I23 (GND VDD B1 net055) INV
    I29 (GND VDD B3 net050) INV
    I28 (GND VDD A3 net051) INV
    I12 (GND VDD A1 net040) INV
ends Adder_5bit

// project_lib/TEST_ABS/schematic
I0 (0 vdd! vdd! 0 0 0 vdd! A0 A1 A2 A3 A4) INV_5bit
I3 (vdd! 0 0 0 vdd! S0 S1 S2 S3 S4 0 OUT0 OUT1 OUT2 OUT3 OUT4 vdd! vdd!) MUX_5bit
I4 (A0 A1 A2 A3 A4 0 0 0 0 0 vdd! net056 0 S0 S1 S2 S3 S4 vdd!) Adder_5bit
include "./_graphical_stimuli.scs"
simulatorOptions options temp=27
tran tran stop=1n
