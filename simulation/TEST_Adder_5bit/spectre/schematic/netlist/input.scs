// Design: project_lib/TEST_Adder_5bit
simulator lang=spectre
global 0 vdd!
include "/usr/public.2/ee115c/cadence-labs/gpdk090_v3.4/models/spectre/gpdk090.scs" section=NN

// project_lib/FAdder/schematic
subckt FAdder \!Cout A B Cin GND S VDD
    NM12 (S net30 GND GND) gpdk090_nmos1v w=(430n) l=100n m=(1)*(1)
    NM11 (net024 A GND GND) gpdk090_nmos1v w=(1.29u) l=100n m=(1)*(1)
    NM10 (net025 B net024 GND) gpdk090_nmos1v w=(1.29u) l=100n m=(1)*(1)
    NM9 (net30 Cin net025 GND) gpdk090_nmos1v w=(1.29u) l=100n m=(1)*(1)
    NM8 (net19 Cin GND GND) gpdk090_nmos1v w=(860n) l=100n m=(1)*(1)
    NM7 (net19 A GND GND) gpdk090_nmos1v w=(860n) l=100n m=(1)*(1)
    NM6 (net19 B GND GND) gpdk090_nmos1v w=(860n) l=100n m=(1)*(1)
    NM5 (net30 \!Cout net19 GND) gpdk090_nmos1v w=(860n) l=100n m=(1)*(1)
    NM4 (\!Cout Cin net11 GND) gpdk090_nmos1v w=(860n) l=100n m=(1)*(1)
    NM3 (\!Cout A net059 GND) gpdk090_nmos1v w=(860n) l=100n m=(1)*(1)
    NM2 (net059 B GND GND) gpdk090_nmos1v w=(860n) l=100n m=(1)*(1)
    NM1 (net11 B GND GND) gpdk090_nmos1v w=(860n) l=100n m=(1)*(1)
    NM0 (net11 A GND GND) gpdk090_nmos1v w=(860n) l=100n m=(1)*(1)
    PM13 (S net30 VDD VDD) gpdk090_pmos1v w=(650n) l=100n m=(1)*(1)
    PM12 (net057 A VDD VDD) gpdk090_pmos1v w=(1.95u) l=100n m=(1)*(1)
    PM10 (net056 B net057 VDD) gpdk090_pmos1v w=(1.95u) l=100n m=(1)*(1)
    PM9 (net30 Cin net056 VDD) gpdk090_pmos1v w=(1.95u) l=100n m=(1)*(1)
    PM8 (net020 Cin VDD VDD) gpdk090_pmos1v w=(1.3u) l=100n m=(1)*(1)
    PM7 (net020 B VDD VDD) gpdk090_pmos1v w=(1.3u) l=100n m=(1)*(1)
    PM6 (net020 A VDD VDD) gpdk090_pmos1v w=(1.3u) l=100n m=(1)*(1)
    PM5 (net30 \!Cout net020 VDD) gpdk090_pmos1v w=(1.3u) l=100n m=(1)*(1)
    PM4 (\!Cout A net058 VDD) gpdk090_pmos1v w=(1.3u) l=100n m=(1)*(1)
    PM3 (net058 B VDD VDD) gpdk090_pmos1v w=(1.3u) l=100n m=(1)*(1)
    PM2 (net037 B VDD VDD) gpdk090_pmos1v w=(1.3u) l=100n m=(1)*(1)
    PM1 (net037 A VDD VDD) gpdk090_pmos1v w=(1.3u) l=100n m=(1)*(1)
    PM0 (\!Cout Cin net037 VDD) gpdk090_pmos1v w=(1.3u) l=100n m=(1)*(1)
ends FAdder

// project_lib/INV/schematic
subckt INV GND VDD Vin Vout
    NM0 (Vout Vin GND GND) gpdk090_nmos1v w=(430n) l=100n m=(1)*(1)
    PM0 (Vout Vin VDD VDD) gpdk090_pmos1v w=(650n) l=100n m=(1)*(1)
ends INV

// project_lib/TEST_Adder_5bit/schematic
I0 (C0 0 0 vdd! 0 S0 vdd!) FAdder
I1 (C1 net100 net94 C0 0 S1 vdd!) FAdder
I2 (C2 vdd! 0 C1 0 S2 vdd!) FAdder
I3 (C3 net101 net102 C2 0 S3 vdd!) FAdder
I4 (net49 0 0 C3 0 S4 vdd!) FAdder
I12 (0 vdd! vdd! net100) INV
I28 (0 vdd! vdd! net101) INV
I29 (0 vdd! 0 net102) INV
I23 (0 vdd! 0 net94) INV
include "./_graphical_stimuli.scs"
simulatorOptions options temp=27
tran tran stop=1n
