// Design: project_lib/MUX_1bit_TEST
simulator lang=spectre
global 0 vdd!
parameters _gpar0
include "/usr/public.2/ee115c/cadence-labs/gpdk090_v3.4/models/spectre/gpdk090.scs" section=NN

// project_lib/INV/schematic
subckt INV GND VDD Vin Vout
    NM0 (Vout Vin GND GND) gpdk090_nmos1v w=(430n) l=100n m=(1)*(1)
    PM0 (Vout Vin VDD VDD) gpdk090_pmos1v w=(650n) l=100n m=(1)*(1)
ends INV

// project_lib/MUX_1bit_TEST/schematic
I4 (0 vdd! 0 \!S) INV
PM1 (OUT 0 0 vdd!) gpdk090_pmos1v w=(430n) l=100n m=(1)*(1)
PM0 (OUT \!S vdd! vdd!) gpdk090_pmos1v w=(430n) l=100n m=(1)*(1)
NM1 (OUT \!S 0 0) gpdk090_nmos1v w=(430n) l=100n m=(1)*(1)
NM0 (OUT 0 vdd! 0) gpdk090_nmos1v w=(430n) l=100n m=(1)*(1)
include "./_graphical_stimuli.scs"
simulatorOptions options temp=27
tran tran stop=2n errpreset=moderate
